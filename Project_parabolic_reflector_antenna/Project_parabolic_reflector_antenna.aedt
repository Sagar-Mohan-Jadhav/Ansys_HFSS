# Ansys Electronics Desktop project, version 2022.2
materials:
  vacuum: permittivity=1
  steel_stainless: conductivity=1100000
  aluminum: permeability=1.000021 conductivity=38000000
  Rogers RO4350 (tm): permittivity=3.66 dielectric_loss_tangent=0.004
  PVC plastic: permittivity=2.7 dielectric_loss_tangent=0.007
  copper: permeability=0.999991 conductivity=58000000

design HFSSDesign1 (HFSS, DrivenTerminal, model units mm)
variables:
  px = 0
  py = 0
  pz = 0
  Rad = 1mm
  Hei = 1mm
  Radius = 1
  Height = 1
geometry:
  Verticle_stand = cylinder(axis=Z, base_centre=(0mm, 0mm, 0mm), radius=40mm, height=600mm)
  Horizontal_stand = cylinder(axis=X, base_centre=(-100mm, 0mm, 600mm), radius=40mm, height=200mm)
  stand [steel_stainless] = cylinder(axis=Y, base_centre=(100mm, -40mm, 600mm), radius=40mm, height=120mm)
  Dish_holder_2 = cylinder(axis=Y, base_centre=(-100mm, -40mm, 600mm), radius=40mm, height=120mm)
  Dish [copper] = equation_based_surface(XuvFunction=_u YuvFunction=_v ZuvFunction=(_u*_u)+(_v*_v) uStart=-400mm uEnd=400mm vStart=-400mm vEnd=400mm)
  Dish.rotate(axis=X, angle=-90deg)
  Dish.move(0mm, 50mm, 600mm)
  Box1 = box(corner=(650mm, 800mm, 0mm), size=(-1550mm, -1300mm, 1500mm))
  Box1.move(0mm, 700mm, 0mm)
  Dish.subtract(Box1)
  Dish.thicken(20mm)
  Dish1 = equation_based_surface(XuvFunction=_u YuvFunction=_v ZuvFunction=(_u*_u)+(_v*_v) uStart=-400mm uEnd=400mm vStart=-400mm vEnd=400mm)
  Dish1.rotate(axis=X, angle=-90deg)
  Dish1.move(0mm, 50mm, 600mm)
  Box2 = box(corner=(650mm, 800mm, 0mm), size=(-1550mm, -1300mm, 1500mm))
  Box2.move(0mm, 700mm, 0mm)
  Dish1.subtract(Box2)
  Dish1.thicken(40mm)
  stand.unite(Dish_holder_2, Horizontal_stand, Verticle_stand)
  stand.subtract(Dish1)
  Holder [steel_stainless] = cylinder(axis=Y, base_centre=(0mm, 40mm, 600mm), radius=10mm, height=552.27931mm)
  Holder.rotate(axis=X, angle=30deg)
  Holder.move(0mm, 131.46845mm, 5.1747103mm)
  Holder.move(0mm, 276.48055mm, -235.07236mm)
  Transmitter_reciever [PVC plastic] = cylinder(axis=Y, base_centre=(0mm, 530mm, 600mm), radius=41.446833mm, height=123.16261mm)
  Substrate [Rogers RO4350 (tm)] = object_from(Transmitter_reciever.face(2 of 3))
  Substrate.sweep_along_vector((0mm, -12mm, 0mm))
  Circular_antenna = circle(normal=Y, centre=(0mm, 518mm, 600mm), radius=25mm)
  Rectangle1 = rectangle(corner=(0mm, 518mm, 604mm), z_size=-8mm, x_size=38mm)
  Rectangle2 = rectangle(corner=(0mm, 518mm, 606mm), z_size=-12mm, x_size=38.730616mm)
  Circular_antenna.subtract(Rectangle2)
  Circular_antenna.unite(Rectangle1)
  Ground_plane = circle(normal=Y, centre=(0mm, 530mm, 600mm), radius=40mm)
  Source = rectangle(corner=(38mm, 518mm, 604mm), y_size=12mm, z_size=-8mm)
  Air [vacuum] = box(corner=(-750mm, -350mm, 0mm), size=(1500mm, 2000mm, 1500mm))
  Holder1 = cylinder(axis=Y, base_centre=(0mm, 40mm, 600mm), radius=10mm, height=552.27931mm)
  Holder1.rotate(axis=X, angle=30deg)
  Holder1.move(0mm, 131.46845mm, 5.1747103mm)
  Holder1.move(0mm, 276.48055mm, -235.07236mm)
  Dish.subtract(Holder1)
  Holder2 = cylinder(axis=Y, base_centre=(0mm, 40mm, 600mm), radius=10mm, height=552.27931mm)
  Holder2.rotate(axis=X, angle=30deg)
  Holder2.move(0mm, 131.46845mm, 5.1747103mm)
  Holder2.move(0mm, 276.48055mm, -235.07236mm)
  Transmitter_reciever.subtract(Holder2)
boundaries and excitations:
  PerfE_antenna: Perfect E Objects=Circular_antenna
  PerfE_ground_plane: Perfect E Objects=Ground_plane
  Radiation: Radiation Faces=Air.face(all 6)
  1: Terminal port=P1 Edges=Circular_antenna.edge(3 of 4) TerminalResistance=50ohm
  P1: Lumped Port Faces=Source.face Impedance=50ohm
  reference conductors: Ground_plane
setups:
  Setup1: HfssDriven Frequency=2.5GHz MaxDeltaS=0.02 MaximumPasses=12 MinimumPasses=1 MinimumConvergedPasses=1 PercentRefinement=20 BasisOrder=1 DoLambdaRefine=false PortAccuracy=2 DrivenSolverType="Direct Solver"
    sweep Sweep: 2.25GHz to 3.25GHz, 21 points; Type=Discrete SaveFields
source amplitudes:
  P1:1: 1V 0deg
radiation setups:
  Infinite Sphere1: Infinite Sphere Theta=0deg..180deg step 2deg Phi=-180deg..180deg step 2deg
reports:
  Terminal S Parameter Plot 1: dB(St(1,1)) vs Freq on Setup1 : Sweep
