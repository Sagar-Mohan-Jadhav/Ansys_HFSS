# Ansys Electronics Desktop project, version 2022.2
materials:
  vacuum: permittivity=1
  steel_stainless: conductivity=1100000

design HFSSDesign1 (HFSS, DrivenTerminal, model units mm)
variables:
  px = 0
  py = 0
  pz = 0
  Rad = 1mm
  Hei = 1mm
  Radius = 1
  Height = 1
geometry:
  Verticle_stand = cylinder(axis=Z, base_centre=(0mm, 0mm, 0mm), radius=40mm, height=600mm)
  Horizontal_stand = cylinder(axis=X, base_centre=(-100mm, 0mm, 600mm), radius=40mm, height=200mm)
  stand [steel_stainless] = cylinder(axis=Y, base_centre=(100mm, -40mm, 600mm), radius=40mm, height=120mm)
  Dish_holder_2 = cylinder(axis=Y, base_centre=(-100mm, -40mm, 600mm), radius=40mm, height=120mm)
  Dish [vacuum] = equation_based_surface(XuvFunction=_u YuvFunction=_v ZuvFunction=(_u*_u)+(_v*_v) uStart=-400mm uEnd=400mm vStart=-400mm vEnd=400mm)
  Dish.rotate(axis=X, angle=-90deg)
  Dish.move(0mm, 50mm, 600mm)
  Box1 = box(corner=(650mm, 800mm, 0mm), size=(-1550mm, -1300mm, 1500mm))
  Box1.move(0mm, 700mm, 0mm)
  Dish.subtract(Box1)
  Dish.thicken(20mm)
  Dish1 = equation_based_surface(XuvFunction=_u YuvFunction=_v ZuvFunction=(_u*_u)+(_v*_v) uStart=-400mm uEnd=400mm vStart=-400mm vEnd=400mm)
  Dish1.rotate(axis=X, angle=-90deg)
  Dish1.move(0mm, 50mm, 600mm)
  Box2 = box(corner=(650mm, 800mm, 0mm), size=(-1550mm, -1300mm, 1500mm))
  Box2.move(0mm, 700mm, 0mm)
  Dish1.subtract(Box2)
  Dish1.thicken(40mm)
  stand.unite(Dish_holder_2, Horizontal_stand, Verticle_stand)
  stand.subtract(Dish1)
  Cylinder1 [steel_stainless] = cylinder(axis=Y, base_centre=(0mm, 40mm, 600mm), radius=10mm, height=552.27931mm)
  Cylinder1.rotate(axis=X, angle=30deg)
  Cylinder1.move(0mm, 131.46845mm, 5.1747103mm)
  Cylinder1.move(0mm, 276.48055mm, -235.07236mm)
